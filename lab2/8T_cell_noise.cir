.INCLUDE model28nm.spi
.INCLUDE 8T_cell_noise.spi

X1    WWL RWL RBL_bad WBL_bad nWBL_bad 1 0 8T_cell_noise M = 31
X2    0 0 RBL WBL nWBL 1 0 8T_cell_noise M = 255
Xcell WWL RWL RBL WBL nWBL 1 0 8T_cell_noise

*
* 1v between VDD (1) and GND (0)
*
VCC 1 0 DC 1.0V

.IC V(RBL) = 1.0V
.IC V(WWL) = 0.0V
.IC V(WBL) = 0.0V
.IC V(nWBL) = 0.0V
.IC V(Xcell.Q) = 1.0V
.IC V(Xcell.QB) = 0.0V
.IC V(Xcell.QN) = 1.0V
.IC V(Xcell.QBN) = 0.0V

.IC V(X1.Q) = 1.0V
.IC V(X1.QB) = 0.0V
.IC V(X1.QN) = 1.0V
.IC V(X1.QBN) = 0.0V
.IC V(X2.Q) = 1.0V
.IC V(X2.QB) = 0.0V
.IC V(X2.QN) = 1.0V
.IC V(X2.QBN) = 0.0V

.IC V(RBL_bad) = 1.0V
.IC V(WBL_bad) = 0.0V
.IC V(nWBL_bad) = 0.0V

*
* Input wave
*

EVNOISER Xcell.Q Xcell.QN VOL='V(Xcell.QB)-V(Xcell.QBN)'

* Part Graphic
VVNOISEL Xcell.QB Xcell.QBN pwl(0ns 0 10ns 0 15ns 1.0 20ns 1.0 25ns 0)

Vin0 RWL 0 pwl(0ns 0 5ns 0 10ns 1 20ns 1 25ns 0)

* Part Analytic
*VVNOISE Xcell.QBN Xcell.QB DC 0V

.TRAN 1ns 30ns

*.MEASURE TRAN SNM FIND V(Xcell.QN) WHEN V(Xcell.Q) = 0V TD=10ns

* Part Analytic
*.control
*destroy all
*let testing_noise=-0.3
** loop to test values below 1.0V
*while (testing_noise<-0.2)
* echo "**********************************************************"
* echo "**********************************************************"
* echo "Testing robustness for a noise voltage of: $&testing_noise"
* alter vvnoise testing_noise
* run
* echo "**********************************************************"
* echo "**********************************************************"
* let testing_noise=testing_noise+0.01
*end
*.endc

.END
