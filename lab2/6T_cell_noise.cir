.INCLUDE model28nm.spi
.INCLUDE 6T_cell_noise.spi

X1    WL BL_Bad nBL_bad  1 0 6T_cell_noise M = 31
X2    0  BL     nBL      1 0 6T_cell_noise M = 255
Xcell WL BL     nBL      1 0 6T_cell_noise

*
* 1v between VDD (1) and GND (0)
*
VCC 1 0 DC 5.0V
.IC V(BL) = 1.0V
.IC V(nBL) = 1.0V
.IC V(BL_Bad) = 1.0V
.IC V(nBL_Bad) = 1.0V
.IC V(Xcell.Q) = 1.0V
.IC V(Xcell.QB) = 0.0V
.IC V(Xcell.QN) = 0.0V
.IC V(Xcell.QBN) = 1.0V

*
* Input wave
*
VWL WL 0 DC 0V
EVNOISER Xcell.Q Xcell.QN VOL='V(Xcell.QB)-V(Xcell.QBN)'

* Part Graphic
VVNOISEL Xcell.QB Xcell.QBN pwl(0ns 0 10ns 0 15ns 1.0 20ns 1.0 25ns 0)

* Part Analytic
*VVNOISE Xcell.QBN Xcell.QB DC 0V

.TRAN 1ns 30ns

* Part Analytic
*.control
*destroy all
*let testing_noise=0.0
** loop to test values below 5.0V
*while (testing_noise<5)
* echo "**********************************************************"
* echo "**********************************************************"
* echo "Testing robustness for a noise voltage of: $&testing_noise"
* alter vvnoise testing_noise
* run
* echo "**********************************************************"
* echo "**********************************************************"
* let testing_noise=testing_noise+0.1
*end
*.endc

* plot V(Xcell.Q) V(Xcell.QBN) V(Xcell.QB) V(Xcell.QN)

.END
