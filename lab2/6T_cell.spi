*6T_cell

.SUBCKT 6T_cell WL BL nBL 1 0

*pull-down transistors
M1   nQ  Q   0 0 tn L=56n W=224n AS=37.6f AD=37.6f PS=784n PD=784n
M3    Q nQ   0 0 tn L=56n W=224n AS=37.6f AD=37.6f PS=784n PD=784n
M5   nQ WL nBL 0 tn L=56n W=112n AS=18.8f AD=18.8f PS=560n PD=560n
M6    Q WL  BL 0 tn L=56n W=112n AS=18.8f AD=18.8f PS=560n PD=560n

*pull-up transistors
M2   1  Q nQ 1 tp L=84n W=84n AS=14.1f AD=14.1f PS=504n PD=504n
M4   1 nQ  Q 1 tp L=84n W=84n AS=14.1f AD=14.1f PS=504n PD=504n

.ENDS 6T_cell
