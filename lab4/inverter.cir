.INCLUDE model28nm.spi

.SUBCKT inv In Out 1 0
M1  1 In Out 1 tp   L=56n W=56n AS=9.5f AD=9.5f PS=448n PD=448n
M2  Out In 0  0 tn L=56n W=112n AS=19f AD=19f PS=560n PD=560n
.ENDS inv

* Ring instantiation

x1 In      InOut12  1 0 inv
x2 InOut12 InOut23  1 0 inv
x3 InOut23 InOut34  1 0 inv
x4 InOut34 InvOut   1 0 inv
C1 InvOut  COut     1UF

VCC 1 0 DC 1.0V

Vin In 0 pwl(0ns 0 0.5ns 1 9.5ns 1 10ns 0)

.TRAN 0.5ns 10ns

.control
run
*set M1 vth0=@tn[vth0]
*set M2 vth0=@tn[vth0]
altermod @tn[vth0] = @tn[vth0] * 0.8
altermod @tp[vth0] = @tp[vth0] * 1.2
run
.endc

.measure tran tpdr trig v(InOut12) val=0.5 fall=1 targ v(InOut23) val=0.5 rise=1
.measure tran tpdf trig v(InOut23) val=0.5 rise=1 targ v(InOut34) val=0.5 fall=1

.END
