.INCLUDE model28nm.spi
.INCLUDE 6T_cell.spi

X1    WL BL_Bad nBL_bad  1 0 6T_cell M = 31
X2    0  BL     nBL      1 0 6T_cell M = 255
Xcell WL BL     nBL      1 0 6T_cell

VCC 1 0 DC 1.0V
.IC V(BL) = 1.0V
.IC V(nBL) = 1.0V
.IC V(BL_Bad) = 1.0V
.IC V(nBL_bad) = 1.0V
.IC V(Xcell.Q) = 1.0V
.IC V(Xcell.nQ) = 0.0V

Vin0 WL 0 pwl(0.5ns 0 1ns 1 9ns 1 9.5ns 0)
EVextra Vdiff 0 VOL='V(BL)-V(nBL)'

.TRAN 1ns 10ns
.MEASURE TRAN delay TRIG V(WL) VAL=0.5 RISE=1 TARG V(Vdiff) VAL=0.05 RISE=1

.control
* Define Vth variations for NMOS (tn) and PMOS (tp)
let tn_variations = {-0.2, 0, +0.2}  * Adjust for desired Vth variations
let tp_variations = {-0.2, 0, +0.2}  * Adjust for desired Vth variations

foreach tn_v ($tn_variations) {
    foreach tp_v ($tp_variations) {
        * Apply Vth modifications for both NMOS and PMOS
        altermod @tn[vth0] = @tn[vth0] * (1 + tn_v)
        altermod @tp[vth0] = @tp[vth0] * (1 + tp_v)

        * Print the current Vth variations
        print "TN Vth variation: ", tn_v, " TP Vth variation: ", tp_v

        * Run the simulation
        run

        * Measure and print the delay for this Vth combination
        print "Delay for TN Vth variation: ", tn_v, " TP Vth variation: ", tp_v, " is ", delay

    }
}
.endc

.END
