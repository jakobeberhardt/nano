*inverter gate
*Output is S

.SUBCKT inverter In Out 1 0

*pull-up transistors
* 1.b.
*M1   1 In Out 1 tp L=56n W=56n AS=3.136f AD=3.136f PS=224n  PD=224n

* 2
*M1   1 In Out 1 tp L=56n W=112n AS=6.27f AD=6.27f PS=336n PD=336n
M1   1 In Out 1 tp L=56n W=100n AS=5.6f AD=5.6f PS=312n PD=312n

*pull-down transistors
M4   Out In 0 0 tn L=56n W=56n AS=3.136f AD=3.136f PS=224n  PD=224n

.ENDS inverter
