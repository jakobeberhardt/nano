* import technology model and gate design

.INCLUDE model28nm.spi
.INCLUDE or_and.spi

* or_and instantiation

x1 in0 in1 in2 out0 I1 I2 1 0 or_and

*
* 1v between VDD (1) and GND (0)
*
VCC 1 0 DC 1.0V

*
* Input wave
*
Vin0 in0 0 pwl(0ns 0 15ns 1 20ns 1 35ns 0)
Vin1 in1 0 pwl(0ns 0 15ns 1 20ns 1 35ns 0)
Vin2 in2 0 pwl(0ns 0 15ns 1 20ns 1 35ns 0)

.TRAN 1ns 40ns

*.plot in0 in1 in2 out0

.END
