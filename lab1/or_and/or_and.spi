*2-input NAND gate
*Output is S

.SUBCKT or_and A B C S I1 I2 1 0

*pull-up transistors
M1   1 A I1 1 tp L=56n W=448n AS=75.3f AD=75.3f PS=1.23u PD=1.23u
M2   I1 B S 1 tp L=56n W=448n AS=75.3f AD=75.3f PS=1.23u PD=1.23u
M3   I1 C S 1 tp L=56n W=448n AS=75.3f AD=75.3f PS=1.23u PD=1.23u

*pull-down transistors
M4   S A 0 0 tn L=56n W=224n AS=37.6f AD=37.6f PS= 784n PD=784n
M5   S B I2 0 tn L=56n W=224n AS=37.6f AD=37.6f PS= 784n PD=784n
M6   I2 C 0 0 tn L=56n W=224n AS=37.6f AD=37.6f PS= 784n PD=784n

.ENDS or_and
